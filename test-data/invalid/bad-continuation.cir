R1 in out 1k
+ dangling continuation without prior line context
.end

* Unknown subcircuit reference
X1 a b missingbuf
.end

.subckt missing_end in out
R1 in out 1k
.end

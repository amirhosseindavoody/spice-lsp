* before
R1 in out 1k
C1 out 0 1u
X1 a b mycell
